ADE simulation setup
Run mode: Monte Carlo Sampling
Tests:
  S1: FinalProject/CUT2_HT1/schematic, simulator spectre
  S2: FinalProject/CUT2_HT1/schematic, simulator spectre
  S3: FinalProject/CUT2_HT1/schematic, simulator spectre
Monte Carlo Sampling options: mcmethod=all, mcnumpoints=200, parasiticanalysis=0
