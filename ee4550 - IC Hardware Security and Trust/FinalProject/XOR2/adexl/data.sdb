ADE simulation setup
Run mode: Monte Carlo Sampling
Tests:
  FinalProject:XOR2:1: FinalProject/XOR2/schematic, simulator spectre
Monte Carlo Sampling options: mcmethod=all, mcnumpoints=200, parasiticanalysis=0
