ADE simulation setup
Run mode: Monte Carlo Sampling
Tests:
  lab5:4bit_FAddSub:1: lab5/4bit_FAddSub/schematic, simulator spectre
Monte Carlo Sampling options: mcmethod=all, mcnumpoints=20, parasiticanalysis=0
