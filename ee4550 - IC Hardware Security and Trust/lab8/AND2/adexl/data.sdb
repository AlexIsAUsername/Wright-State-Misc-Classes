ADE simulation setup
Run mode: Monte Carlo Sampling
Tests:
  FinalProject:AND2:1: FinalProject/AND2/schematic, simulator spectre
Monte Carlo Sampling options: mcmethod=all, mcnumpoints=200, parasiticanalysis=0
