ADE simulation setup
Run mode: Monte Carlo Sampling
Tests:
  FinalProject:INV:1: FinalProject/INV/schematic, simulator spectre
Monte Carlo Sampling options: mcmethod=all, mcnumpoints=200, parasiticanalysis=0
