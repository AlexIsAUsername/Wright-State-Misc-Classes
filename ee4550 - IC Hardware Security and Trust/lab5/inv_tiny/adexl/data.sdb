ADE simulation setup
Run mode: Single Run, Sweeps and Corners
Tests:
  lab5:inv_tiny:1: lab5/inv_tiny/schematic, simulator spectre
