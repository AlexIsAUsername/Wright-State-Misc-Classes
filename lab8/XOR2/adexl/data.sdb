ADE simulation setup
Run mode: Monte Carlo Sampling
Tests:
  FinalProject:XOR:1: FinalProject/XOR/schematic, simulator spectre
Monte Carlo Sampling options: mcmethod=all, mcnumpoints=200, parasiticanalysis=0
