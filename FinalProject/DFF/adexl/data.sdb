ADE simulation setup
Run mode: Monte Carlo Sampling
Tests:
  FinalProject:DFF:1: FinalProject/DFF/schematic, simulator spectre
Monte Carlo Sampling options: mcmethod=all, mcnumpoints=200, parasiticanalysis=0
